defun( AFn_OpenDesign (@key design, (mode "w"), noMru, noConfirm, forceNew)
 let((noconfirmStatus, result)
  when(noConfirm, noconfirmStatus = axlGetVariable("NOCONFIRM"), axlSetVariable("NOCONFIRM", t))
  when(forceNew && isFile(design), deleteFile(design))
  result = if(noMru && axlVersion('version) >= 16.0
   then axlOpenDesign(?design design, ?mode mode, ?noMru t)
   else axlOpenDesign(?design design, ?mode mode)
  )
  when(noConfirm, if(noconfirmStatus then axlSetVariable("NOCONFIRM", t) else axlUnsetVariable("NOCONFIRM")))
  result
))
procedure( CreatePadstacks()
    axlDBChangeDesignUnits("millimeters" 4)
    pad_list0 = cons(make_axlPadStackPad(
        ?layer "TOP", ?type 'REGULAR,
        ?figure 'RECTANGLE, ?figureSize 0.7:1.5) nil)
    ps_id = axlDBCreatePadStack("r150_70", nil, pad_list0 t)
    axlPadstackToDisk("r150_70")
)
procedure( BuildFootprint()
    AFn_OpenDesign(?design strcat("RN4871", ".dra"), ?mode "wf", ?noMru t, ?noConfirm t, ?forceNew t)
    axlSetSymbolType("package")
    mytext = make_axlTextOrientation(?textBlock 6, ?rotation 0, ?mirrored nil, ?justify "center")
    mypin = make_axlPinText(?number "1", ?offset 0:0, ?text mytext)
    axlDBCreatePin("r150_70" 95.75:106.7 mypin 90)
    mypin = make_axlPinText(?number "2", ?offset 0:0, ?text mytext)
    axlDBCreatePin("r150_70" 95.75:105.5 mypin 90)
    mypin = make_axlPinText(?number "3", ?offset 0:0, ?text mytext)
    axlDBCreatePin("r150_70" 95.75:104.3 mypin 90)
    mypin = make_axlPinText(?number "4", ?offset 0:0, ?text mytext)
    axlDBCreatePin("r150_70" 95.75:103.1 mypin 90)
    mypin = make_axlPinText(?number "5", ?offset 0:0, ?text mytext)
    axlDBCreatePin("r150_70" 95.75:101.9 mypin 90)
    mypin = make_axlPinText(?number "6", ?offset 0:0, ?text mytext)
    axlDBCreatePin("r150_70" 97:100.25 mypin 180)
    mypin = make_axlPinText(?number "7", ?offset 0:0, ?text mytext)
    axlDBCreatePin("r150_70" 98.2:100.25 mypin 180)
    mypin = make_axlPinText(?number "8", ?offset 0:0, ?text mytext)
    axlDBCreatePin("r150_70" 99.4:100.25 mypin 180)
    mypin = make_axlPinText(?number "9", ?offset 0:0, ?text mytext)
    axlDBCreatePin("r150_70" 100.6:100.25 mypin 180)
    mypin = make_axlPinText(?number "10", ?offset 0:0, ?text mytext)
    axlDBCreatePin("r150_70" 101.8:100.25 mypin 180)
    mypin = make_axlPinText(?number "11", ?offset 0:0, ?text mytext)
    axlDBCreatePin("r150_70" 103:100.25 mypin 180)
    mypin = make_axlPinText(?number "12", ?offset 0:0, ?text mytext)
    axlDBCreatePin("r150_70" 104.25:101.9 mypin 90)
    mypin = make_axlPinText(?number "13", ?offset 0:0, ?text mytext)
    axlDBCreatePin("r150_70" 104.25:103.1 mypin 90)
    mypin = make_axlPinText(?number "14", ?offset 0:0, ?text mytext)
    axlDBCreatePin("r150_70" 104.25:104.3 mypin 90)
    mypin = make_axlPinText(?number "15", ?offset 0:0, ?text mytext)
    axlDBCreatePin("r150_70" 104.25:105.5 mypin 90)
    mypin = make_axlPinText(?number "16", ?offset 0:0, ?text mytext)
    axlDBCreatePin("r150_70" 104.25:106.7 mypin 90)
    axlDBCreateText("IC*" 99.57504:104.40673 "2" "REF DES/SILKSCREEN_TOP")
    axlDBCreateLine((list 95.5:111.5 104.5:111.5), 0.2, "PACKAGE GEOMETRY/ASSEMBLY_TOP")
    axlDBCreateLine((list 104.5:111.5 104.5:100), 0.2, "PACKAGE GEOMETRY/ASSEMBLY_TOP")
    axlDBCreateLine((list 104.5:100 95.5:100), 0.2, "PACKAGE GEOMETRY/ASSEMBLY_TOP")
    axlDBCreateLine((list 95.5:100 95.5:111.5), 0.2, "PACKAGE GEOMETRY/ASSEMBLY_TOP")
    axlDBCreateLine((list 95.5:111.5 104.5:111.5), 0.2, "PACKAGE GEOMETRY/SILKSCREEN_TOP")
    axlDBCreateLine((list 95.5:111.5 95.5:107.475), 0.2, "PACKAGE GEOMETRY/SILKSCREEN_TOP")
    axlDBCreateLine((list 104.5:111.5 104.5:107.475), 0.2, "PACKAGE GEOMETRY/SILKSCREEN_TOP")
    axlDBCreateLine((list 95.5:100 95.5:101.139), 0.2, "PACKAGE GEOMETRY/SILKSCREEN_TOP")
    axlDBCreateLine((list 104.5:100 104.5:101.139), 0.2, "PACKAGE GEOMETRY/SILKSCREEN_TOP")
    axlDBCreateLine((list 95.5:100 96.285:100), 0.2, "PACKAGE GEOMETRY/SILKSCREEN_TOP")
    axlDBCreateLine((list 104.5:100 103.715:100), 0.2, "PACKAGE GEOMETRY/SILKSCREEN_TOP")
    axlDBCreateCircle((list 94.373:106.741 0.045), 0.2, "PACKAGE GEOMETRY/SILKSCREEN_TOP")
    ;axlCompileSymbol(?symbol "RN4871", ?type "package")
    axlSaveDesign(?noMru t)
)
